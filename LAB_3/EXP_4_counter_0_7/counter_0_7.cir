* EXP_4 - 0 to 7 up counter (74LS74)
* behavioural model, runs in LTspice and ngspice
.model swl SW(Ron=1 Roff=1e12 Vt=2.5 Vh=0.1)
.subckt dff d clk pre clr q qn
* xung hep rong o canh day duong cua clock
RCL  clk  clk_d 1
CCL  clk_d 0 1n
B_EDGE edge 0 V = ((V(clk) > 2.5) * (V(clk_d) <= 2.5)) ? 5 : 0
* lay mau D trong xung hep, giu bang tu
S1 qs d edge 0 swl
C1 qs 0 5p IC=0
R1 qs 0 1e12
* preset / clear bat dong, muc thap, PRE uu tien khi ca hai cung tac dong
B_PRESW presw 0 V = (5 - V(pre)) * V(clr) / 5
B_CLRSW clrsw 0 V = (5 - V(clr)) * V(pre) / 5
S2 qs v5 presw 0 swl
S3 qs 0 clrsw 0 swl
V5 v5 0 5
B_Q  q  0 V = (V(pre) < 2.5) ? 5 : ((V(clr) < 2.5) ? 0 : V(qs))
B_QN qn 0 V = ((V(pre) < 2.5) * (V(clr) < 2.5)) ? 5 : ((V(pre) < 2.5) ? 0 : ((V(clr) < 2.5) ? 5 : (V(qs) > 2.5 ? 0 : 5)))
.ends dff
V_CLK clk 0 PWL(0n 0 19n 0 20n 5 29n 5 30n 0 39n 0 40n 5 49n 5 50n 0 59n 0 60n 5 69n 5 70n 0 79n 0 80n 5 89n 5 90n 0 99n 0 100n 5 109n 5 110n 0 119n 0 120n 5 129n 5 130n 0 139n 0 140n 5 149n 5 150n 0 159n 0 160n 5 169n 5 170n 0 179n 0 180n 5 189n 5 190n 0 199n 0 200n 5 209n 5 210n 0 219n 0 220n 5 229n 5 230n 0 239n 0 240n 5 249n 5 250n 0 259n 0 260n 5 269n 5 270n 0 279n 0 280n 5 289n 5 290n 0 299n 0 300n 5 309n 5 310n 0 319n 0 320n 5 329n 5 330n 0)
V_A   a   0 PWL(0n 0 89n 0 90n 5)
V_B   b   0 PWL(0n 5 89n 5 90n 0 154n 0 155n 5)
V_CLR clr 0 PWL(0n 5 1n 5 2n 0 7n 0 8n 5 91n 5 92n 5 93n 5 94n 0 97n 0 98n 5 163n 5 164n 5 165n 5 166n 0 169n 0 170n 5)
RDL0 q0 q0d 5
CDL0 q0d 0 1n
RDL1 q1 q1d 5
CDL1 q1d 0 1n
RDL2 q2 q2d 5
CDL2 q2d 0 1n
B_D0 d0 0 V = (V(a) > 2.5) ? ((V(q0d) > 2.5) ? 0 : 5) : V(q0d)
B_D1 d1 0 V = (V(b) > 2.5) ? ((V(q1d) > 2.5) ? 0 : 5) : V(q1d)
B_D2 d2 0 V = (V(q2d) > 2.5) ? 0 : 5
X0 d0 clk pre0 clr q0 q0n dff
X1 d1 q0n pre0 clr q1 q1n dff
X2 d2 q1n pre0 clr q2 q2n dff
R_DUMMY q2n 0 1e12
V_PRE0 pre0 0 5
.tran 0.2n 350n
.end
