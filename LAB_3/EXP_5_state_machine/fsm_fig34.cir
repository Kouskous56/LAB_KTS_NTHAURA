* EXP_5 - state machine (Figure 3.4)
* behavioural model, runs in LTspice and ngspice
.model swl SW(Ron=1 Roff=1e12 Vt=2.5 Vh=0.1)
.subckt dff d clk pre clr q qn
* xung hep rong o canh day duong cua clock
RCL  clk  clk_d 1
CCL  clk_d 0 1n
B_EDGE edge 0 V = ((V(clk) > 2.5) * (V(clk_d) <= 2.5)) ? 5 : 0
* lay mau D trong xung hep, giu bang tu
S1 qs d edge 0 swl
C1 qs 0 5p IC=0
R1 qs 0 1e12
* preset / clear bat dong, muc thap, PRE uu tien khi ca hai cung tac dong
B_PRESW presw 0 V = (5 - V(pre)) * V(clr) / 5
B_CLRSW clrsw 0 V = (5 - V(clr)) * V(pre) / 5
S2 qs v5 presw 0 swl
S3 qs 0 clrsw 0 swl
V5 v5 0 5
B_Q  q  0 V = (V(pre) < 2.5) ? 5 : ((V(clr) < 2.5) ? 0 : V(qs))
B_QN qn 0 V = ((V(pre) < 2.5) * (V(clr) < 2.5)) ? 5 : ((V(pre) < 2.5) ? 0 : ((V(clr) < 2.5) ? 5 : (V(qs) > 2.5 ? 0 : 5)))
.ends dff
V_CLK clk 0 PWL(0n 0 19n 0 20n 5 29n 5 30n 0 39n 0 40n 5 49n 5 50n 0 59n 0 60n 5 69n 5 70n 0 79n 0 80n 5 89n 5 90n 0 99n 0 100n 5 109n 5 110n 0 119n 0 120n 5 129n 5 130n 0 139n 0 140n 5 149n 5 150n 0)
V_X   x   0 PWL(0n 0 15n 0 16n 0 35n 0 36n 5 55n 5 56n 5 75n 5 76n 0 95n 0 96n 0 115n 0 116n 0 135n 0 136n 5)
V_CLR clr 0 PWL(0n 5 1n 5 2n 0 5n 0 6n 5)
RDL0 q0 q0d 5
CDL0 q0d 0 1n
RDL1 q1 q1d 5
CDL1 q1d 0 1n
B_S1P s1p 0 V = (V(x)*V(q0d) > 12.5) ? 5 : 0
B_S0P s0p 0 V = (V(x)*(5 - V(q1d))*(5 - V(q0d)) > 12.5) ? 5 : 0
X1 s1p clk pre0 clr q1 q1n dff
X0 s0p clk pre0 clr q0 q0n dff
V_PRE0 pre0 0 5
.tran 0.2n 180n
.end
