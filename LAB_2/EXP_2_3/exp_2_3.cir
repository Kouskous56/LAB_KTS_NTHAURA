* EXP_2_3 - F = NOR(NOR(x,yz), NAND(~y,x))
* gate level behavioural model, runs in LTspice and ngspice
V_X x 0 PWL(0n 0 399n 0 400n 5 799n 5 800n 0)
V_Y y 0 PWL(0n 0 199n 0 200n 5 399n 5 400n 0 599n 0 600n 5 799n 5 800n 0)
V_Z z 0 PWL(0n 0 99n 0 100n 5 199n 5 200n 0 299n 0 300n 5 399n 5 400n 0 499n 0 500n 5 599n 5 600n 0 699n 0 700n 5 799n 5 800n 0)
B_YZ  yz 0 V = V(y)*V(z) > 12.5 ? 5 : 0
B_A   A  0 V = V(x)+V(yz) > 2.5 ? 0 : 5
B_NY  ny 0 V = (V(y) > 2.5) ? 0 : 5
B_B   B  0 V = V(ny)*V(x) > 12.5 ? 0 : 5
B_F   F  0 V = V(A)+V(B) > 2.5 ? 0 : 5
B_FS  Fs 0 V = V(x)*V(ny) > 12.5 ? 5 : 0
.tran 2n 800n
.end
