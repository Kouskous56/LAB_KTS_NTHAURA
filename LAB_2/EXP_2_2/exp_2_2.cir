* EXP_2_2 - F = sum m(0,1,3,4,7)
* gate level behavioural model, runs in LTspice and ngspice
V_X x 0 PWL(0n 0 399n 0 400n 5 799n 5 800n 0)
V_Y y 0 PWL(0n 0 199n 0 200n 5 399n 5 400n 0 599n 0 600n 5 799n 5 800n 0)
V_Z z 0 PWL(0n 0 99n 0 100n 5 199n 5 200n 0 299n 0 300n 5 399n 5 400n 0 499n 0 500n 5 599n 5 600n 0 699n 0 700n 5 799n 5 800n 0)
B_NX nx 0 V = (V(x) > 2.5) ? 0 : 5
B_NY ny 0 V = (V(y) > 2.5) ? 0 : 5
B_NZ nz 0 V = (V(z) > 2.5) ? 0 : 5
B_A1 a1 0 V = V(y)*V(z) > 12.5 ? 5 : 0
B_A2 a2 0 V = V(nx)*V(ny) > 12.5 ? 5 : 0
B_A3 a3 0 V = V(ny)*V(nz) > 12.5 ? 5 : 0
B_F  F  0 V = V(a1)+V(a2)+V(a3) > 2.5 ? 5 : 0
.tran 2n 800n
.end
