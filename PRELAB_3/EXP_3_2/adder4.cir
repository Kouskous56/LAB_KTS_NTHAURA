* 4 bit ripple adder - LTspice / ngspice transient analysis
* gate level behavioural model, runs in LTspice and ngspice
V_A0 a0 0 PWL(0n 0 99n 0 100n 5 199n 5 200n 0 299n 0 300n 5 399n 5 400n 0 499n 0 500n 5 599n 5 600n 0 699n 0 700n 5 799n 5 800n 0 899n 0 900n 5 999n 5 1000n 0 1099n 0 1100n 5 1199n 5 1200n 0 1299n 0 1300n 5 1399n 5 1400n 0 1499n 0 1500n 5 1599n 5 1600n 0)
V_A1 a1 0 PWL(0n 0 199n 0 200n 5 399n 5 400n 0 599n 0 600n 5 799n 5 800n 0 999n 0 1000n 5 1199n 5 1200n 0 1399n 0 1400n 5 1599n 5 1600n 0)
V_A2 a2 0 PWL(0n 0 399n 0 400n 5 799n 5 800n 0 1199n 0 1200n 5 1599n 5 1600n 0)
V_A3 a3 0 PWL(0n 0 799n 0 800n 5 1599n 5 1600n 0)
V_B0 b0 0 5
V_B1 b1 0 5
V_B2 b2 0 0
V_B3 b3 0 0
V_CI ci 0 0
B_T10 t0 0 V = V(a0)+V(b0) > 2.5 ? (V(a0)+V(b0) < 7.5 ? 5 : 0) : 0
B_S0  s0 0 V = V(t0)+V(ci) > 2.5 ? (V(t0)+V(ci) < 7.5 ? 5 : 0) : 0
B_X0  x0 0 V = V(a0)*V(b0) > 12.5 ? 5 : 0
B_Y0  y0 0 V = V(t0)*V(ci) > 12.5 ? 5 : 0
B_C1  c1 0 V = V(x0)+V(y0) > 2.5 ? 5 : 0
B_T11 t1 0 V = V(a1)+V(b1) > 2.5 ? (V(a1)+V(b1) < 7.5 ? 5 : 0) : 0
B_S1  s1 0 V = V(t1)+V(c1) > 2.5 ? (V(t1)+V(c1) < 7.5 ? 5 : 0) : 0
B_X1  x1 0 V = V(a1)*V(b1) > 12.5 ? 5 : 0
B_Y1  y1 0 V = V(t1)*V(c1) > 12.5 ? 5 : 0
B_C2  c2 0 V = V(x1)+V(y1) > 2.5 ? 5 : 0
B_T12 t2 0 V = V(a2)+V(b2) > 2.5 ? (V(a2)+V(b2) < 7.5 ? 5 : 0) : 0
B_S2  s2 0 V = V(t2)+V(c2) > 2.5 ? (V(t2)+V(c2) < 7.5 ? 5 : 0) : 0
B_X2  x2 0 V = V(a2)*V(b2) > 12.5 ? 5 : 0
B_Y2  y2 0 V = V(t2)*V(c2) > 12.5 ? 5 : 0
B_C3  c3 0 V = V(x2)+V(y2) > 2.5 ? 5 : 0
B_T13 t3 0 V = V(a3)+V(b3) > 2.5 ? (V(a3)+V(b3) < 7.5 ? 5 : 0) : 0
B_S3  s3 0 V = V(t3)+V(c3) > 2.5 ? (V(t3)+V(c3) < 7.5 ? 5 : 0) : 0
B_X3  x3 0 V = V(a3)*V(b3) > 12.5 ? 5 : 0
B_Y3  y3 0 V = V(t3)*V(c3) > 12.5 ? 5 : 0
B_C4  c4 0 V = V(x3)+V(y3) > 2.5 ? 5 : 0
.tran 2n 1600n
.end
